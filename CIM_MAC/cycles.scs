#

simulator lang = spice

# normal version
.param T0s_0='clockslew'
.measure T0s_0_point PARAM='T0s_0'
.param T1s_0='T0s_0+half_cycle'
.measure T1s_0_point PARAM='T1s_0'
.param T1e_0='T1s_0+clockslew'
.measure T1e_0_point PARAM='T1e_0'
.param T2s_0='T1e_0+half_cycle'
.measure T2s_0_point PARAM='T2s_0'
.param T2e_0='T2s_0+clockslew'
.measure T2e_0_point PARAM='T2e_0'
.param T3s_0='T2e_0+half_cycle'
.measure T3s_0_point PARAM='T3s_0'
.param T4e_0='T3s_0+clockslew'
.measure T4e_0_point PARAM='T4e_0'
.param T5s_0='T4e_0+half_cycle'
.measure T5s_0_point PARAM='T5s_0'

.param T0s_1='T5s_0+clockslew'
.measure T0s_1_point PARAM='T0s_1'
.param T1s_1='T0s_1+half_cycle'
.measure T1s_1_point PARAM='T1s_1'
.param T1e_1='T1s_1+clockslew'
.measure T1e_1_point PARAM='T1e_1'
.param T2s_1='T1e_1+half_cycle'
.measure T2s_1_point PARAM='T2s_1'
.param T2e_1='T2s_1+clockslew'
.measure T2e_1_point PARAM='T2e_1'
.param T3s_1='T2e_1+half_cycle'
.measure T3s_1_point PARAM='T3s_1'
.param T4e_1='T3s_1+clockslew'
.measure T4e_1_point PARAM='T4e_1'
.param T5s_1='T4e_1+half_cycle'
.measure T5s_1_point PARAM='T5s_1'

.param T0s_2='T5s_1+clockslew'
.measure T0s_2_point PARAM='T0s_2'
.param T1s_2='T0s_2+half_cycle'
.measure T1s_2_point PARAM='T1s_2'
.param T1e_2='T1s_2+clockslew'
.measure T1e_2_point PARAM='T1e_2'
.param T2s_2='T1e_2+half_cycle'
.measure T2s_2_point PARAM='T2s_2'
.param T2e_2='T2s_2+clockslew'
.measure T2e_2_point PARAM='T2e_2'
.param T3s_2='T2e_2+half_cycle'
.measure T3s_2_point PARAM='T3s_2'
.param T4e_2='T3s_2+clockslew'
.measure T4e_2_point PARAM='T4e_2'
.param T5s_2='T4e_2+half_cycle'
.measure T5s_2_point PARAM='T5s_2'

.param T0s_3='T5s_2+clockslew'
.measure T0s_3_point PARAM='T0s_3'
.param T1s_3='T0s_3+half_cycle'
.measure T1s_3_point PARAM='T1s_3'
.param T1e_3='T1s_3+clockslew'
.measure T1e_3_point PARAM='T1e_3'
.param T2s_3='T1e_3+half_cycle'
.measure T2s_3_point PARAM='T2s_3'
.param T2e_3='T2s_3+clockslew'
.measure T2e_3_point PARAM='T2e_3'
.param T3s_3='T2e_3+half_cycle'
.measure T3s_3_point PARAM='T3s_3'
.param T4e_3='T3s_3+clockslew'
.measure T4e_3_point PARAM='T4e_3'
.param T5s_3='T4e_3+half_cycle'
.measure T5s_3_point PARAM='T5s_3'

.param T0s_4='T5s_3+clockslew'
.measure T0s_4_point PARAM='T0s_4'
.param T1s_4='T0s_4+half_cycle'
.measure T1s_4_point PARAM='T1s_4'
.param T1e_4='T1s_4+clockslew'
.measure T1e_4_point PARAM='T1e_4'
.param T2s_4='T1e_4+half_cycle'
.measure T2s_4_point PARAM='T2s_4'
.param T2e_4='T2s_4+clockslew'
.measure T2e_4_point PARAM='T2e_4'
.param T3s_4='T2e_4+half_cycle'
.measure T3s_4_point PARAM='T3s_4'
.param T4e_4='T3s_4+clockslew'
.measure T4e_4_point PARAM='T4e_4'
.param T5s_4='T4e_4+half_cycle'
.measure T5s_4_point PARAM='T5s_4'

.param T0s_5='T5s_4+clockslew'
.measure T0s_5_point PARAM='T0s_5'
.param T1s_5='T0s_5+half_cycle'
.measure T1s_5_point PARAM='T1s_5'
.param T1e_5='T1s_5+clockslew'
.measure T1e_5_point PARAM='T1e_5'
.param T2s_5='T1e_5+half_cycle'
.measure T2s_5_point PARAM='T2s_5'
.param T2e_5='T2s_5+clockslew'
.measure T2e_5_point PARAM='T2e_5'
.param T3s_5='T2e_5+half_cycle'
.measure T3s_5_point PARAM='T3s_5'
.param T4e_5='T3s_5+clockslew'
.measure T4e_5_point PARAM='T4e_5'
.param T5s_5='T4e_5+half_cycle'
.measure T5s_5_point PARAM='T5s_5'

.param T0s_6='T5s_5+clockslew'
.measure T0s_6_point PARAM='T0s_6'
.param T1s_6='T0s_6+half_cycle'
.measure T1s_6_point PARAM='T1s_6'
.param T1e_6='T1s_6+clockslew'
.measure T1e_6_point PARAM='T1e_6'
.param T2s_6='T1e_6+half_cycle'
.measure T2s_6_point PARAM='T2s_6'
.param T2e_6='T2s_6+clockslew'
.measure T2e_6_point PARAM='T2e_6'
.param T3s_6='T2e_6+half_cycle'
.measure T3s_6_point PARAM='T3s_6'
.param T4e_6='T3s_6+clockslew'
.measure T4e_6_point PARAM='T4e_6'
.param T5s_6='T4e_6+half_cycle'
.measure T5s_6_point PARAM='T5s_6'

.param T0s_7='T5s_6+clockslew'
.measure T0s_7_point PARAM='T0s_7'
.param T1s_7='T0s_7+half_cycle'
.measure T1s_7_point PARAM='T1s_7'
.param T1e_7='T1s_7+clockslew'
.measure T1e_7_point PARAM='T1e_7'
.param T2s_7='T1e_7+half_cycle'
.measure T2s_7_point PARAM='T2s_7'
.param T2e_7='T2s_7+clockslew'
.measure T2e_7_point PARAM='T2e_7'
.param T3s_7='T2e_7+half_cycle'
.measure T3s_7_point PARAM='T3s_7'
.param T4e_7='T3s_7+clockslew'
.measure T4e_7_point PARAM='T4e_7'
.param T5s_7='T4e_7+half_cycle'
.measure T5s_7_point PARAM='T5s_7'

.param T0s_8='T5s_7+clockslew'
.measure T0s_8_point PARAM='T0s_8'
.param T1s_8='T0s_8+half_cycle'
.measure T1s_8_point PARAM='T1s_8'
.param T1e_8='T1s_8+clockslew'
.measure T1e_8_point PARAM='T1e_8'
.param T2s_8='T1e_8+half_cycle'
.measure T2s_8_point PARAM='T2s_8'
.param T2e_8='T2s_8+clockslew'
.measure T2e_8_point PARAM='T2e_8'
.param T3s_8='T2e_8+half_cycle'
.measure T3s_8_point PARAM='T3s_8'
.param T4e_8='T3s_8+clockslew'
.measure T4e_8_point PARAM='T4e_8'
.param T5s_8='T4e_8+half_cycle'
.measure T5s_8_point PARAM='T5s_8'

.param T0s_9='T5s_8+clockslew'
.measure T0s_9_point PARAM='T0s_9'
.param T1s_9='T0s_9+half_cycle'
.measure T1s_9_point PARAM='T1s_9'
.param T1e_9='T1s_9+clockslew'
.measure T1e_9_point PARAM='T1e_9'
.param T2s_9='T1e_9+half_cycle'
.measure T2s_9_point PARAM='T2s_9'
.param T2e_9='T2s_9+clockslew'
.measure T2e_9_point PARAM='T2e_9'
.param T3s_9='T2e_9+half_cycle'
.measure T3s_9_point PARAM='T3s_9'
.param T4e_9='T3s_9+clockslew'
.measure T4e_9_point PARAM='T4e_9'
.param T5s_9='T4e_9+half_cycle'
.measure T5s_9_point PARAM='T5s_9'

.param T0s_10='T5s_9+clockslew'
.measure T0s_10_point PARAM='T0s_10'
.param T1s_10='T0s_10+half_cycle'
.measure T1s_10_point PARAM='T1s_10'
.param T1e_10='T1s_10+clockslew'
.measure T1e_10_point PARAM='T1e_10'
.param T2s_10='T1e_10+half_cycle'
.measure T2s_10_point PARAM='T2s_10'
.param T2e_10='T2s_10+clockslew'
.measure T2e_10_point PARAM='T2e_10'
.param T3s_10='T2e_10+half_cycle'
.measure T3s_10_point PARAM='T3s_10'
.param T4e_10='T3s_10+clockslew'
.measure T4e_10_point PARAM='T4e_10'
.param T5s_10='T4e_10+half_cycle'
.measure T5s_10_point PARAM='T5s_10'

# delay version
.param T0s_0d='delay+clockslew'
.measure T0s_0d_point PARAM='T0s_0d'
.param T1s_0d='T0s_0d+half_cycle'
.measure T1s_0d_point PARAM='T1s_0d'
.param T1e_0d='T1s_0d+clockslew'
.measure T1e_0d_point PARAM='T1e_0d'
.param T2s_0d='T1e_0d+half_cycle'
.measure T2s_0d_point PARAM='T2s_0d'
.param T2e_0d='T2s_0d+clockslew'
.measure T2e_0d_point PARAM='T2e_0d'
.param T3s_0d='T2e_0d+half_cycle'
.measure T3s_0d_point PARAM='T3s_0d'
.param T4e_0d='T3s_0d+clockslew'
.measure T4e_0d_point PARAM='T4e_0d'
.param T5s_0d='T4e_0d+half_cycle'
.measure T5s_0d_point PARAM='T5s_0d'

.param T0s_1d='T5s_0d+clockslew'
.measure T0s_1d_point PARAM='T0s_1d'
.param T1s_1d='T0s_1d+half_cycle'
.measure T1s_1d_point PARAM='T1s_1d'
.param T1e_1d='T1s_1d+clockslew'
.measure T1e_1d_point PARAM='T1e_1d'
.param T2s_1d='T1e_1d+half_cycle'
.measure T2s_1d_point PARAM='T2s_1d'
.param T2e_1d='T2s_1d+clockslew'
.measure T2e_1d_point PARAM='T2e_1d'
.param T3s_1d='T2e_1d+half_cycle'
.measure T3s_1d_point PARAM='T3s_1d'
.param T4e_1d='T3s_1d+clockslew'
.measure T4e_1d_point PARAM='T4e_1d'
.param T5s_1d='T4e_1d+half_cycle'
.measure T5s_1d_point PARAM='T5s_1d'

.param T0s_2d='T5s_1d+clockslew'
.measure T0s_2d_point PARAM='T0s_2d'
.param T1s_2d='T0s_2d+half_cycle'
.measure T1s_2d_point PARAM='T1s_2d'
.param T1e_2d='T1s_2d+clockslew'
.measure T1e_2d_point PARAM='T1e_2d'
.param T2s_2d='T1e_2d+half_cycle'
.measure T2s_2d_point PARAM='T2s_2d'
.param T2e_2d='T2s_2d+clockslew'
.measure T2e_2d_point PARAM='T2e_2d'
.param T3s_2d='T2e_2d+half_cycle'
.measure T3s_2d_point PARAM='T3s_2d'
.param T4e_2d='T3s_2d+clockslew'
.measure T4e_2d_point PARAM='T4e_2d'
.param T5s_2d='T4e_2d+half_cycle'
.measure T5s_2d_point PARAM='T5s_2d'

.param T0s_3d='T5s_2d+clockslew'
.measure T0s_3d_point PARAM='T0s_3d'
.param T1s_3d='T0s_3d+half_cycle'
.measure T1s_3d_point PARAM='T1s_3d'
.param T1e_3d='T1s_3d+clockslew'
.measure T1e_3d_point PARAM='T1e_3d'
.param T2s_3d='T1e_3d+half_cycle'
.measure T2s_3d_point PARAM='T2s_3d'
.param T2e_3d='T2s_3d+clockslew'
.measure T2e_3d_point PARAM='T2e_3d'
.param T3s_3d='T2e_3d+half_cycle'
.measure T3s_3d_point PARAM='T3s_3d'
.param T4e_3d='T3s_3d+clockslew'
.measure T4e_3d_point PARAM='T4e_3d'
.param T5s_3d='T4e_3d+half_cycle'
.measure T5s_3d_point PARAM='T5s_3d'

.param T0s_4d='T5s_3d+clockslew'
.measure T0s_4d_point PARAM='T0s_4d'
.param T1s_4d='T0s_4d+half_cycle'
.measure T1s_4d_point PARAM='T1s_4d'
.param T1e_4d='T1s_4d+clockslew'
.measure T1e_4d_point PARAM='T1e_4d'
.param T2s_4d='T1e_4d+half_cycle'
.measure T2s_4d_point PARAM='T2s_4d'
.param T2e_4d='T2s_4d+clockslew'
.measure T2e_4d_point PARAM='T2e_4d'
.param T3s_4d='T2e_4d+half_cycle'
.measure T3s_4d_point PARAM='T3s_4d'
.param T4e_4d='T3s_4d+clockslew'
.measure T4e_4d_point PARAM='T4e_4d'
.param T5s_4d='T4e_4d+half_cycle'
.measure T5s_4d_point PARAM='T5s_4d'

.param T0s_5d='T5s_4d+clockslew'
.measure T0s_5d_point PARAM='T0s_5d'
.param T1s_5d='T0s_5d+half_cycle'
.measure T1s_5d_point PARAM='T1s_5d'
.param T1e_5d='T1s_5d+clockslew'
.measure T1e_5d_point PARAM='T1e_5d'
.param T2s_5d='T1e_5d+half_cycle'
.measure T2s_5d_point PARAM='T2s_5d'
.param T2e_5d='T2s_5d+clockslew'
.measure T2e_5d_point PARAM='T2e_5d'
.param T3s_5d='T2e_5d+half_cycle'
.measure T3s_5d_point PARAM='T3s_5d'
.param T4e_5d='T3s_5d+clockslew'
.measure T4e_5d_point PARAM='T4e_5d'
.param T5s_5d='T4e_5d+half_cycle'
.measure T5s_5d_point PARAM='T5s_5d'

.param T0s_6d='T5s_5d+clockslew'
.measure T0s_6d_point PARAM='T0s_6d'
.param T1s_6d='T0s_6d+half_cycle'
.measure T1s_6d_point PARAM='T1s_6d'
.param T1e_6d='T1s_6d+clockslew'
.measure T1e_6d_point PARAM='T1e_6d'
.param T2s_6d='T1e_6d+half_cycle'
.measure T2s_6d_point PARAM='T2s_6d'
.param T2e_6d='T2s_6d+clockslew'
.measure T2e_6d_point PARAM='T2e_6d'
.param T3s_6d='T2e_6d+half_cycle'
.measure T3s_6d_point PARAM='T3s_6d'
.param T4e_6d='T3s_6d+clockslew'
.measure T4e_6d_point PARAM='T4e_6d'
.param T5s_6d='T4e_6d+half_cycle'
.measure T5s_6d_point PARAM='T5s_6d'

.param T0s_7d='T5s_6d+clockslew'
.measure T0s_7d_point PARAM='T0s_7d'
.param T1s_7d='T0s_7d+half_cycle'
.measure T1s_7d_point PARAM='T1s_7d'
.param T1e_7d='T1s_7d+clockslew'
.measure T1e_7d_point PARAM='T1e_7d'
.param T2s_7d='T1e_7d+half_cycle'
.measure T2s_7d_point PARAM='T2s_7d'
.param T2e_7d='T2s_7d+clockslew'
.measure T2e_7d_point PARAM='T2e_7d'
.param T3s_7d='T2e_7d+half_cycle'
.measure T3s_7d_point PARAM='T3s_7d'
.param T4e_7d='T3s_7d+clockslew'
.measure T4e_7d_point PARAM='T4e_7d'
.param T5s_7d='T4e_7d+half_cycle'
.measure T5s_7d_point PARAM='T5s_7d'

.param T0s_8d='T5s_7d+clockslew'
.measure T0s_8d_point PARAM='T0s_8d'
.param T1s_8d='T0s_8d+half_cycle'
.measure T1s_8d_point PARAM='T1s_8d'
.param T1e_8d='T1s_8d+clockslew'
.measure T1e_8d_point PARAM='T1e_8d'
.param T2s_8d='T1e_8d+half_cycle'
.measure T2s_8d_point PARAM='T2s_8d'
.param T2e_8d='T2s_8d+clockslew'
.measure T2e_8d_point PARAM='T2e_8d'
.param T3s_8d='T2e_8d+half_cycle'
.measure T3s_8d_point PARAM='T3s_8d'
.param T4e_8d='T3s_8d+clockslew'
.measure T4e_8d_point PARAM='T4e_8d'
.param T5s_8d='T4e_8d+half_cycle'
.measure T5s_8d_point PARAM='T5s_8d'

.param T0s_9d='T5s_8d+clockslew'
.measure T0s_9d_point PARAM='T0s_9d'
.param T1s_9d='T0s_9d+half_cycle'
.measure T1s_9d_point PARAM='T1s_9d'
.param T1e_9d='T1s_9d+clockslew'
.measure T1e_9d_point PARAM='T1e_9d'
.param T2s_9d='T1e_9d+half_cycle'
.measure T2s_9d_point PARAM='T2s_9d'
.param T2e_9d='T2s_9d+clockslew'
.measure T2e_9d_point PARAM='T2e_9d'
.param T3s_9d='T2e_9d+half_cycle'
.measure T3s_9d_point PARAM='T3s_9d'
.param T4e_9d='T3s_9d+clockslew'
.measure T4e_9d_point PARAM='T4e_9d'
.param T5s_9d='T4e_9d+half_cycle'
.measure T5s_9d_point PARAM='T5s_9d'

.param T0s_10d='T5s_9d+clockslew'
.measure T0s_10d_point PARAM='T0s_10d'
.param T1s_10d='T0s_10d+half_cycle'
.measure T1s_10d_point PARAM='T1s_10d'
.param T1e_10d='T1s_10d+clockslew'
.measure T1e_10d_point PARAM='T1e_10d'
.param T2s_10d='T1e_10d+half_cycle'
.measure T2s_10d_point PARAM='T2s_10d'
.param T2e_10d='T2s_10d+clockslew'
.measure T2e_10d_point PARAM='T2e_10d'
.param T3s_10d='T2e_10d+half_cycle'
.measure T3s_10d_point PARAM='T3s_10d'
.param T4e_10d='T3s_10d+clockslew'
.measure T4e_10d_point PARAM='T4e_10d'
.param T5s_10d='T4e_10d+half_cycle'
.measure T5s_10d_point PARAM='T5s_10d'

.param T0s_11d='T5s_10d+clockslew'
.measure T0s_11d_point PARAM='T0s_11d'
.param T1s_11d='T0s_11d+end_half_cycle'
.measure T1s_11d_point PARAM='T1s_11d'
.param T1e_11d='T1s_11d+clockslew'
.measure T1e_11d_point PARAM='T1e_11d'
.param T2s_11d='T1e_11d+half_cycle'
.measure T2s_11d_point PARAM='T2s_11d'
.param T2e_11d='T2s_11d+clockslew'
.measure T2e_11d_point PARAM='T2e_11d'
.param T3s_11d='T2e_11d+check_half_cycle'
.measure T3s_11d_point PARAM='T3s_11d'
.param T4e_11d='T3s_11d+clockslew'
.measure T4e_11d_point PARAM='T4e_11d'
.param T5s_11d='T4e_11d+check_half_cycle'
.measure T5s_11d_point PARAM='T5s_11d'
